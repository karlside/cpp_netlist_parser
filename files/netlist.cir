simulator lang = spectre more
global 0
subckt some text
more text
ends \\
more
hallo
hei
