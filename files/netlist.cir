simulator lang=spectre \\
global 0
subckt some text
more text
ends
more
hallo
hei
