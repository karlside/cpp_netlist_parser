simulator lang = spectre more
global 0
device (1 2 3) some more
subckt some text
more text
ends \\
more
hallo
hei
